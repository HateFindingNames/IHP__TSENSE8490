* NGSPICE file created from div16.ext - technology: ihp-sg13cmos5l

* Black-box entry subcircuit for sg13cmos5l_decap_8 abstract view
*.subckt sg13cmos5l_decap_8 VDD VSS
*.ends

* Black-box entry subcircuit for sg13cmos5l_fill_2 abstract view
*.subckt sg13cmos5l_fill_2 VDD VSS
*.ends

* Black-box entry subcircuit for sg13cmos5l_fill_1 abstract view
*.subckt sg13cmos5l_fill_1 VDD VSS
*.ends

* Black-box entry subcircuit for sg13cmos5l_inv_1 abstract view
*.subckt sg13cmos5l_inv_1 Y A VDD VSS
*.ends

* Black-box entry subcircuit for sg13cmos5l_decap_4 abstract view
*.subckt sg13cmos5l_decap_4 VDD VSS
*.ends

* Black-box entry subcircuit for sg13cmos5l_buf_1 abstract view
*.subckt sg13cmos5l_buf_1 X A VDD VSS
*.ends

* Black-box entry subcircuit for sg13cmos5l_dfrbpq_1 abstract view
*.subckt sg13cmos5l_dfrbpq_1 Q CLK D RESET_B VDD VSS
*.ends

* Black-box entry subcircuit for sg13cmos5l_dlygate4sd3_1 abstract view
*.subckt sg13cmos5l_dlygate4sd3_1 X A VDD VSS
*.ends

.subckt div16 VGND VPWR clk_in meas_en q0 q1 q2 q3
XFILLER_0_35 VPWR VGND sg13cmos5l_decap_8
XFILLER_3_45 VPWR VGND sg13cmos5l_decap_8
XFILLER_0_14 VPWR VGND sg13cmos5l_decap_8
XFILLER_6_35 VPWR VGND sg13cmos5l_decap_8
XFILLER_6_46 VPWR VGND sg13cmos5l_fill_2
XFILLER_1_0 VPWR VGND sg13cmos5l_decap_8
XFILLER_3_59 VPWR VGND sg13cmos5l_fill_2
XFILLER_6_14 VPWR VGND sg13cmos5l_decap_8
XFILLER_0_28 VPWR VGND sg13cmos5l_decap_8
XFILLER_0_49 VPWR VGND sg13cmos5l_decap_8
XFILLER_3_38 VPWR VGND sg13cmos5l_decap_8
XFILLER_5_8 VPWR VGND sg13cmos5l_decap_8
XFILLER_6_59 VPWR VGND sg13cmos5l_fill_2
XFILLER_1_60 VPWR VGND sg13cmos5l_fill_1
XFILLER_6_28 VPWR VGND sg13cmos5l_decap_8
X_08_ _08_/Y _15_/A VPWR VGND sg13cmos5l_inv_1
X_09_ _09_/Y _15_/A VPWR VGND sg13cmos5l_inv_1
XFILLER_4_52 VPWR VGND sg13cmos5l_decap_4
XFILLER_1_21 VPWR VGND sg13cmos5l_decap_8
XFILLER_1_7 VPWR VGND sg13cmos5l_decap_8
XFILLER_4_45 VPWR VGND sg13cmos5l_decap_4
XFILLER_4_56 VPWR VGND sg13cmos5l_fill_1
XFILLER_6_0 VPWR VGND sg13cmos5l_decap_8
Xinput1 _15_/A meas_en VPWR VGND sg13cmos5l_buf_1
XFILLER_1_14 VPWR VGND sg13cmos5l_decap_8
XFILLER_1_58 VPWR VGND sg13cmos5l_fill_2
XFILLER_4_14 VPWR VGND sg13cmos5l_decap_4
XFILLER_4_0 VPWR VGND sg13cmos5l_decap_8
XFILLER_2_0 VPWR VGND sg13cmos5l_decap_8
XFILLER_2_52 VPWR VGND sg13cmos5l_decap_4
XFILLER_6_7 VPWR VGND sg13cmos5l_decap_8
XFILLER_2_42 VPWR VGND sg13cmos5l_fill_1
XFILLER_5_30 VPWR VGND sg13cmos5l_decap_4
XFILLER_0_0 VPWR VGND sg13cmos5l_decap_8
XFILLER_2_21 VPWR VGND sg13cmos5l_decap_8
XFILLER_4_7 VPWR VGND sg13cmos5l_decap_8
XFILLER_5_22 VPWR VGND sg13cmos5l_decap_4
X_19_ _19_/Q _18_/Q _19_/D _10_/Y VPWR VGND sg13cmos5l_dfrbpq_1
XFILLER_2_56 VPWR VGND sg13cmos5l_fill_1
X_18_ _18_/Q _17_/Q _18_/D _09_/Y VPWR VGND sg13cmos5l_dfrbpq_1
XFILLER_2_35 VPWR VGND sg13cmos5l_decap_8
X_17_ _17_/Q _16_/Q _17_/D _08_/Y VPWR VGND sg13cmos5l_dfrbpq_1
XFILLER_2_14 VPWR VGND sg13cmos5l_decap_8
XFILLER_2_7 VPWR VGND sg13cmos5l_decap_8
X_16_ _16_/Q clk_in _16_/D _15_/Y VPWR VGND sg13cmos5l_dfrbpq_1
Xhold6 _11_/A _16_/Q VPWR VGND sg13cmos5l_dlygate4sd3_1
XFILLER_5_15 VPWR VGND sg13cmos5l_decap_4
XFILLER_5_26 VPWR VGND sg13cmos5l_fill_1
X_15_ _15_/Y _15_/A VPWR VGND sg13cmos5l_inv_1
XFILLER_0_60 VPWR VGND sg13cmos5l_fill_1
XFILLER_0_7 VPWR VGND sg13cmos5l_decap_8
XFILLER_2_28 VPWR VGND sg13cmos5l_decap_4
X_14_ _19_/D _19_/Q VPWR VGND sg13cmos5l_inv_1
X_12_ _17_/D _17_/Q VPWR VGND sg13cmos5l_inv_1
X_13_ _18_/D _18_/Q VPWR VGND sg13cmos5l_inv_1
X_11_ _16_/D _11_/A VPWR VGND sg13cmos5l_inv_1
XFILLER_0_42 VPWR VGND sg13cmos5l_decap_8
XFILLER_3_52 VPWR VGND sg13cmos5l_decap_8
X_10_ _10_/Y _15_/A VPWR VGND sg13cmos5l_inv_1
Xoutput2 q0 _16_/Q VPWR VGND sg13cmos5l_buf_1
XFILLER_0_21 VPWR VGND sg13cmos5l_decap_8
XFILLER_6_52 VPWR VGND sg13cmos5l_decap_8
Xoutput3 q1 _17_/Q VPWR VGND sg13cmos5l_buf_1
XFILLER_6_21 VPWR VGND sg13cmos5l_decap_8
XFILLER_6_42 VPWR VGND sg13cmos5l_decap_4
Xoutput4 q2 _18_/Q VPWR VGND sg13cmos5l_buf_1
XFILLER_0_56 VPWR VGND sg13cmos5l_decap_4
XFILLER_3_0 VPWR VGND sg13cmos5l_fill_2
Xoutput5 q3 _19_/Q VPWR VGND sg13cmos5l_buf_1
.ends
