* NGSPICE file created from div16.ext - technology: ihp-sg13cmos5l

* Black-box entry subcircuit for sg13cmos5l_decap_8 abstract view
.subckt sg13cmos5l_decap_8 VDD VSS
.ends

* Black-box entry subcircuit for sg13cmos5l_fill_2 abstract view
*.subckt sg13cmos5l_fill_2 VDD VSS
*.ends

* Black-box entry subcircuit for sg13cmos5l_fill_1 abstract view
*.subckt sg13cmos5l_fill_1 VDD VSS
*.ends

* Black-box entry subcircuit for sg13cmos5l_inv_1 abstract view
.subckt sg13cmos5l_inv_1 VDD VSS A Y
.ends

* Black-box entry subcircuit for sg13cmos5l_decap_4 abstract view
.subckt sg13cmos5l_decap_4 VDD VSS
.ends

* Black-box entry subcircuit for sg13cmos5l_buf_1 abstract view
.subckt sg13cmos5l_buf_1 VSS X VDD A
.ends

* Black-box entry subcircuit for sg13cmos5l_dfrbpq_1 abstract view
.subckt sg13cmos5l_dfrbpq_1 VSS RESET_B Q D CLK VDD
.ends

* Black-box entry subcircuit for sg13cmos5l_dlygate4sd3_1 abstract view
.subckt sg13cmos5l_dlygate4sd3_1 VDD VSS X A
.ends

.subckt div16 CLK ENN Q0 Q1 Q2 Q3 VDD VSS
XFILLER_0_35 VDD VSS sg13cmos5l_decap_8
XFILLER_3_45 VDD VSS sg13cmos5l_decap_8
XFILLER_0_14 VDD VSS sg13cmos5l_decap_8
XFILLER_6_35 VDD VSS sg13cmos5l_decap_8
XFILLER_6_46 VDD VSS sg13cmos5l_fill_2
XFILLER_1_0 VDD VSS sg13cmos5l_decap_8
XFILLER_3_59 VDD VSS sg13cmos5l_fill_2
XFILLER_6_14 VDD VSS sg13cmos5l_decap_8
XFILLER_0_28 VDD VSS sg13cmos5l_decap_8
XFILLER_0_49 VDD VSS sg13cmos5l_decap_8
XFILLER_3_38 VDD VSS sg13cmos5l_decap_8
XFILLER_5_8 VDD VSS sg13cmos5l_decap_8
XFILLER_6_59 VDD VSS sg13cmos5l_fill_2
XFILLER_1_60 VDD VSS sg13cmos5l_fill_1
XFILLER_6_28 VDD VSS sg13cmos5l_decap_8
X_08_ _08_/Y _15_/A VDD VSS sg13cmos5l_inv_1
X_09_ _09_/Y _15_/A VDD VSS sg13cmos5l_inv_1
XFILLER_4_52 VDD VSS sg13cmos5l_decap_4
XFILLER_1_21 VDD VSS sg13cmos5l_decap_8
XFILLER_1_7 VDD VSS sg13cmos5l_decap_8
XFILLER_4_45 VDD VSS sg13cmos5l_decap_4
XFILLER_4_56 VDD VSS sg13cmos5l_fill_1
XFILLER_6_0 VDD VSS sg13cmos5l_decap_8
Xinput1 _15_/A ENN VDD VSS sg13cmos5l_buf_1
XFILLER_1_14 VDD VSS sg13cmos5l_decap_8
XFILLER_1_58 VDD VSS sg13cmos5l_fill_2
XFILLER_4_14 VDD VSS sg13cmos5l_decap_4
XFILLER_4_0 VDD VSS sg13cmos5l_decap_8
XFILLER_2_0 VDD VSS sg13cmos5l_decap_8
XFILLER_2_52 VDD VSS sg13cmos5l_decap_4
XFILLER_6_7 VDD VSS sg13cmos5l_decap_8
XFILLER_2_42 VDD VSS sg13cmos5l_fill_1
XFILLER_5_30 VDD VSS sg13cmos5l_decap_4
XFILLER_0_0 VDD VSS sg13cmos5l_decap_8
XFILLER_2_21 VDD VSS sg13cmos5l_decap_8
XFILLER_4_7 VDD VSS sg13cmos5l_decap_8
XFILLER_5_22 VDD VSS sg13cmos5l_decap_4
X_19_ _19_/Q _18_/Q _19_/D _10_/Y VDD VSS sg13cmos5l_dfrbpq_1
XFILLER_2_56 VDD VSS sg13cmos5l_fill_1
X_18_ _18_/Q _17_/Q _18_/D _09_/Y VDD VSS sg13cmos5l_dfrbpq_1
XFILLER_2_35 VDD VSS sg13cmos5l_decap_8
X_17_ _17_/Q _16_/Q _17_/D _08_/Y VDD VSS sg13cmos5l_dfrbpq_1
XFILLER_2_14 VDD VSS sg13cmos5l_decap_8
XFILLER_2_7 VDD VSS sg13cmos5l_decap_8
X_16_ _16_/Q CLK _16_/D _15_/Y VDD VSS sg13cmos5l_dfrbpq_1
Xhold6 _11_/A _16_/Q VDD VSS sg13cmos5l_dlygate4sd3_1
XFILLER_5_15 VDD VSS sg13cmos5l_decap_4
XFILLER_5_26 VDD VSS sg13cmos5l_fill_1
X_15_ _15_/Y _15_/A VDD VSS sg13cmos5l_inv_1
XFILLER_0_60 VDD VSS sg13cmos5l_fill_1
XFILLER_0_7 VDD VSS sg13cmos5l_decap_8
XFILLER_2_28 VDD VSS sg13cmos5l_decap_4
X_14_ _19_/D _19_/Q VDD VSS sg13cmos5l_inv_1
X_12_ _17_/D _17_/Q VDD VSS sg13cmos5l_inv_1
X_13_ _18_/D _18_/Q VDD VSS sg13cmos5l_inv_1
X_11_ _16_/D _11_/A VDD VSS sg13cmos5l_inv_1
XFILLER_0_42 VDD VSS sg13cmos5l_decap_8
XFILLER_3_52 VDD VSS sg13cmos5l_decap_8
X_10_ _10_/Y _15_/A VDD VSS sg13cmos5l_inv_1
Xoutput2 Q0 _16_/Q VDD VSS sg13cmos5l_buf_1
XFILLER_0_21 VDD VSS sg13cmos5l_decap_8
XFILLER_6_52 VDD VSS sg13cmos5l_decap_8
Xoutput3 Q1 _17_/Q VDD VSS sg13cmos5l_buf_1
XFILLER_6_21 VDD VSS sg13cmos5l_decap_8
XFILLER_6_42 VDD VSS sg13cmos5l_decap_4
Xoutput4 Q2 _18_/Q VDD VSS sg13cmos5l_buf_1
XFILLER_0_56 VDD VSS sg13cmos5l_decap_4
XFILLER_3_0 VDD VSS sg13cmos5l_fill_2
Xoutput5 Q3 _19_/Q VDD VSS sg13cmos5l_buf_1
.ends
