** sch_path: /foss/designs/TSENSE8490-main/schematic/xschem/lvs-view/TSENSE8490.sch
.subckt TSENSE8490 ENN ENP Q0 Q1 Q2 Q3 RO_BUF RO_RAW VDD VSS
*.PININFO ENP:B ENN:B RO_RAW:B RO_BUF:B Q0:B Q1:B Q2:B Q3:B
x3 VDD VSS RO_BUF ENN Q0 Q1 Q2 Q3
X4 VDD bondpad
X5 VSS bondpad
X6 ENP bondpad
X7 ENN bondpad
X8 RO_RAW bondpad
X9 RO_BUF bondpad
X10 Q0 bondpad
X11 Q1 bondpad
X12 Q2 bondpad
X13 Q3 bondpad
DD1 VDD ENP VSS diodevdd_4kv
DD2 VDD ENP VSS diodevss_4kv
DD3 VDD ENN VSS diodevdd_4kv
DD4 VDD ENN VSS diodevss_4kv
DD5 VDD RO_RAW VSS diodevdd_4kv
DD6 VDD RO_RAW VSS diodevss_4kv
DD7 VDD RO_BUF VSS diodevdd_4kv
DD8 VDD RO_BUF VSS diodevss_4kv
DD9 VDD Q0 VSS diodevdd_4kv
DD10 VDD Q0 VSS diodevss_4kv
DD11 VDD Q1 VSS diodevdd_4kv
DD12 VDD Q1 VSS diodevss_4kv
DD13 VDD Q2 VSS diodevdd_4kv
DD14 VDD Q2 VSS diodevss_4kv
DD15 VDD Q3 VSS diodevdd_4kv
DD16 VDD Q3 VSS diodevss_4kv
MM1 net13 net1 VDD VDD sg13_lv_pmos w=1.5u l=0.46u ng=1
MM21 net1 ENP VDD VDD sg13_lv_pmos w=10u l=0.13u ng=1
MM22 net2 ENN VSS VSS sg13_lv_nmos w=10u l=0.13u ng=1
MM23 net1 net1 VDD VDD sg13_lv_pmos w=1.5u l=0.46u ng=1
MM24 net2 net2 VSS VSS sg13_lv_nmos w=1.5u l=0.46u ng=1
MM4 net22 net2 VSS VSS sg13_lv_nmos w=1.5u l=0.46u ng=1
MM5 net14 net1 VDD VDD sg13_lv_pmos w=1.5u l=0.46u ng=1
MM8 net23 net2 VSS VSS sg13_lv_nmos w=1.5u l=0.46u ng=1
MM9 net15 net1 VDD VDD sg13_lv_pmos w=1.5u l=0.46u ng=1
MM12 net24 net2 VSS VSS sg13_lv_nmos w=1.5u l=0.46u ng=1
MM13 net16 net1 VDD VDD sg13_lv_pmos w=1.5u l=0.46u ng=1
MM16 net25 net2 VSS VSS sg13_lv_nmos w=1.5u l=0.46u ng=1
MM17 net17 net1 VDD VDD sg13_lv_pmos w=1.5u l=0.46u ng=1
MM20 net26 net2 VSS VSS sg13_lv_nmos w=1.5u l=0.46u ng=1
MM25 net18 net1 VDD VDD sg13_lv_pmos w=1.5u l=0.46u ng=1
MM28 net27 net2 VSS VSS sg13_lv_nmos w=1.5u l=0.46u ng=1
MM29 net19 net1 VDD VDD sg13_lv_pmos w=1.5u l=0.46u ng=1
MM32 net28 net2 VSS VSS sg13_lv_nmos w=1.5u l=0.46u ng=1
MM2 VSS net3 net1 VDD sg13_lv_pmos w=1u l=0.13u ng=1
MM3 VDD net4 net2 VSS sg13_lv_nmos w=1u l=0.13u ng=1
RR6 VDD net3 1.047k $SUB=sub! $[rsil] w=0.5e-6 l=75e-6
RR7 net3 VSS 155.3 $SUB=sub! $[rsil] w=0.5e-6 l=10e-6
RR1 net4 VSS 1.047k $SUB=sub! $[rsil] w=0.5e-6 l=75e-6
RR2 VDD net4 155.3 $SUB=sub! $[rsil] w=0.5e-6 l=10e-6
MM6 net20 net1 VDD VDD sg13_lv_pmos w=1.5u l=0.46u ng=1
MM7 net29 net2 VSS VSS sg13_lv_nmos w=1.5u l=0.46u ng=1
MM10 net21 net1 VDD VDD sg13_lv_pmos w=1.5u l=0.46u ng=1
MM11 net30 net2 VSS VSS sg13_lv_nmos w=1.5u l=0.46u ng=1
MM14 RO_RAW ENP VDD VDD sg13_lv_pmos w=0.3u l=0.13u ng=1
MM15 net5 RO_RAW net22 VSS sg13_lv_nmos w=0.74u l=0.13u ng=1
MM18 net13 RO_RAW net5 VDD sg13_lv_pmos w=1.12u l=0.13u ng=1
MM19 net6 net5 net23 VSS sg13_lv_nmos w=0.74u l=0.13u ng=1
MM26 net14 net5 net6 VDD sg13_lv_pmos w=1.12u l=0.13u ng=1
MM27 net7 net6 net24 VSS sg13_lv_nmos w=0.74u l=0.13u ng=1
MM30 net15 net6 net7 VDD sg13_lv_pmos w=1.12u l=0.13u ng=1
MM31 net8 net7 net25 VSS sg13_lv_nmos w=0.74u l=0.13u ng=1
MM33 net16 net7 net8 VDD sg13_lv_pmos w=1.12u l=0.13u ng=1
MM34 net9 net8 net26 VSS sg13_lv_nmos w=0.74u l=0.13u ng=1
MM35 net17 net8 net9 VDD sg13_lv_pmos w=1.12u l=0.13u ng=1
MM36 net10 net9 net27 VSS sg13_lv_nmos w=0.74u l=0.13u ng=1
MM37 net18 net9 net10 VDD sg13_lv_pmos w=1.12u l=0.13u ng=1
MM38 net11 net10 net28 VSS sg13_lv_nmos w=0.74u l=0.13u ng=1
MM39 net19 net10 net11 VDD sg13_lv_pmos w=1.12u l=0.13u ng=1
MM40 net12 net11 net29 VSS sg13_lv_nmos w=0.74u l=0.13u ng=1
MM41 net20 net11 net12 VDD sg13_lv_pmos w=1.12u l=0.13u ng=1
MM42 RO_RAW net12 net30 VSS sg13_lv_nmos w=0.74u l=0.13u ng=1
MM43 net21 net12 RO_RAW VDD sg13_lv_pmos w=1.12u l=0.13u ng=1
MM44 net31 RO_RAW VSS VSS sg13_lv_nmos w=2.0u l=0.45u ng=1
MM45 VDD RO_RAW net31 VDD sg13_lv_pmos w=1.0u l=0.45u ng=1
MM46 net32 net31 VSS VSS sg13_lv_nmos w=3.99u l=0.45u ng=3
MM47 VDD net31 net32 VDD sg13_lv_pmos w=2.0u l=0.45u ng=1
MM48 RO_BUF net32 VSS VSS sg13_lv_nmos w=16.0u l=0.45u ng=5
MM49 VDD net32 RO_BUF VDD sg13_lv_pmos w=7.995u l=0.45u ng=3
RR3 VSS sub! ptap1 A=6.084e-13 P=3.12e-06
.ends

* expanding   symbol:  TSENSE8490-main/schematic/xschem/digital/div16/xschem/div16.sym # of pins=8
** sym_path: /foss/designs/TSENSE8490-main/schematic/xschem/digital/div16/xschem/div16.sym

* Black-box entry subcircuit for div16 abstract view
.subckt div16 VDD VSS RO_BUF ENN Q0 Q1 Q2 Q3
.ends

.GLOBAL sub!
